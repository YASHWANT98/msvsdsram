// Design: SCL180_Design/Tristate_buffer
simulator lang=spectre
global 0

// SCL180_Design/Tristate_buffer/schematic
M2 (net3 net1 0 0) n18 w=0.42 l=0.18 m=1
M1 (Out EN net3 0) n18 w=0.42 l=0.18 m=1
M0 (net1 IN 0 0) n18 w=0.42 l=0.18 m=1
M5 (net2 net1 VDD VDD) p18 w=0.42 l=0.18 m=1
M4 (Out EN_bar net2 VDD) p18 w=0.42 l=0.18 m=1
M3 (net1 IN VDD VDD) p18 w=0.42 l=0.18 m=1
V2 (IN 0) vsource type=pulse val0=0 val1=1.8 period=10n width=5n
V1 (EN 0) vsource type=pulse val0=0 val1=1.8 period=40n width=20n
V0 (EN_bar 0) vsource type=pulse val0=1.8 val1=0 period=40n width=20n
V3 (VDD 0) vsource dc=1.8 type=dc
simulatorOptions options temp=27
