// Design: SCL180_Design/Sense_Amplifier
simulator lang=spectre
global 0

// SCL180_Design/Sense_Amplifier/schematic
M2 (net1 net1 VDD VDD) p18 w=0.42 l=0.18 m=1
M1 (Dout Out VDD VDD) p18 w=0.84 l=0.18 m=1
M0 (Out net1 VDD VDD) p18 w=0.42 l=0.18 m=1
M6 (net2 Rd_EN 0 0) n18 w=1.26 l=0.18 m=1
M5 (Out BL net2 0) n18 w=0.42 l=0.18 m=1
M4 (Dout Out 0 0) n18 w=0.42 l=0.18 m=1
M3 (net1 BLbar net2 0) n18 w=0.42 l=0.18 m=1
V0 (VDD 0) vsource dc=1.8 type=dc
V3 (BLbar 0) vsource type=pulse val0=0 val1=1.8 period=2n width=1n
V2 (BL 0) vsource type=pulse val0=1.8 val1=0 period=2n width=1n
V1 (Rd_EN 0) vsource type=pulse val0=1.8 val1=0 period=10n width=5n
simulatorOptions options temp=27
