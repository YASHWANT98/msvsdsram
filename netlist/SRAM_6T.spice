// Design: SCL180_Design/SRAM_6T
simulator lang=spectre
global 0

// SCL180_Design/SRAM_6T/schematic
M6 (net2 net4 0 0) n18 w=0.42 l=0.18 m=1
M3 (Qbar WL BLBAR 0) n18 w=0.42 l=0.18 m=1
M2 (BL WL Q 0) n18 w=0.42 l=0.18 m=1
M1 (Q Qbar 0 0) n18 w=0.42 l=0.18 m=1
M0 (Qbar Q 0 0) n18 w=0.42 l=0.18 m=1
M7 (net2 net4 net1 net1) p18 w=0.42 l=0.18 m=1
M5 (Q Qbar VDD VDD) p18 w=0.84 l=0.18 m=1
M4 (Qbar Q VDD VDD) p18 w=0.84 l=0.18 m=1
V3 (net1 0) vsource dc=1.8 type=dc
V4 (VDD 0) vsource dc=1.8 type=dc
V5 (net3 0) vsource type=pulse val0=0 val1=1.8 period=10n width=5n
V1 (Q 0) vsource type=pulse val0=0 val1=1.8 period=10n width=5n
V2 (WL 0) vsource type=pulse val0=0 val1=1.8 period=40n width=19n
simulatorOptions options temp=27
