// Design: SCL180_Design/Precharge_Circuit
simulator lang=spectre
global 0
include "/home/yashwantmoses/Desktop/scl_pdk_v2/design_kit/models/hspice/ts18sl_scl.lib" section=tt_18

// SCL180_Design/Precharge_Circuit/schematic
M1 (BL Precharge VDD VDD) p18 w=0.84 l=0.18 m=1
M0 (BLbar Precharge VDD VDD) p18 w=0.84 l=0.18 m=1
V0 (VDD 0) vsource dc=1.8 type=dc
V1 (Precharge 0) vsource type=pulse val0=0 val1=1.8 period=10n width=5n
simulatorOptions options temp=27
