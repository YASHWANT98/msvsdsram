// Design: SCL180_Design/D_flipflop
simulator lang=spectre
global 0

// SCL180_Design/D_flipflop/schematic
M17 (net1 CLK net4 net4) p18 w=0.42 l=0.18 m=1
M7 (VDD Q net4 VDD) p18 w=0.42 l=0.18 m=1
M6 (Q net1 VDD VDD) p18 w=0.42 l=0.18 m=1
M5 (net3 CLKbar net1 net3) p18 w=0.42 l=0.18 m=1
M4 (net3 net6 VDD VDD) p18 w=0.42 l=0.18 m=1
M3 (CLKbar CLK VDD VDD) p18 w=0.42 l=0.18 m=1
M2 (VDD net3 net2 VDD) p18 w=0.42 l=0.18 m=1
M1 (net6 CLKbar net2 net2) p18 w=0.42 l=0.18 m=1
M0 (D CLK net6 D) p18 w=0.42 l=0.18 m=1
M16 (net1 CLKbar net4 net4) n18 w=0.42 l=0.18 m=1
M15 (0 Q net4 0) n18 w=0.42 l=0.18 m=1
M14 (Q net1 0 0) n18 w=0.42 l=0.18 m=1
M13 (net3 CLK net1 net3) n18 w=0.42 l=0.18 m=1
M12 (net3 net6 0 0) n18 w=0.42 l=0.18 m=1
M11 (CLKbar CLK 0 0) n18 w=0.42 l=0.18 m=1
M10 (0 net3 net2 0) n18 w=0.42 l=0.18 m=1
M9 (net6 CLK net2 net2) n18 w=0.42 l=0.18 m=1
M8 (D CLKbar net6 D) n18 w=0.42 l=0.18 m=1
V0 (VDD 0) vsource dc=1.8 type=dc
V2 (D 0) vsource type=pulse val0=0 val1=1.8 period=30n delay=2.5n width=15n
V1 (CLK 0) vsource type=pulse val0=1.8 val1=0 period=10n width=5n
simulatorOptions options temp=27
